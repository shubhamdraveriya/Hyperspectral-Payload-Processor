// HPDP register map (SPEC.md section 8), on M_AXI_HPM0_FPD at 0xA000_0000.
//
// regs/generate.py turns this file into the SystemVerilog register block
// (rtl/regs/), the C header (sw/baremetal/common/hpdp_regs.h), address
// constants for the testbenches and host tools, and HTML documentation.
//
// Every block starts with ID at 0x00; CTRL 0x04, STATUS 0x08, IRQ_EN 0x0C and
// IRQ_STATUS 0x10 where the block has them; block registers from 0x40;
// CNT_CLEAR at 0x7C and the block's counters from 0x80. Counters are 32 bit
// and saturate. The register block runs on clk_ctrl; configuration reaches the
// data path clocks (and status comes back) within about a microsecond:
// SYS.STATUS.cfg_pending shows when all writes have arrived.

reg block_id #(longint unsigned BLOCK = 0) {
    name = "Block ID";
    field { sw = r; hw = na; desc = "Block identifier"; } block[31:16] = BLOCK;
    field { sw = r; hw = na; desc = "Version (major, minor)"; } version[15:0] = 16'h0100;
};

reg counter {
    field { sw = r; hw = w; desc = "Saturating count, cleared through CNT_CLEAR"; } count[31:0];
};

reg cnt_clear {
    name = "Counter clear";
    field {
        sw = rw; hw = r; singlepulse;
        desc = "Write 1 to clear this block's counters";
    } clear[0:0] = 0;
};

// ---------------------------------------------------------------------------
regfile hpdp_sys {
    name = "System";
    desc = "Identification, global control, image geometry, interrupts";

    block_id #(.BLOCK(16'h4850)) ID @ 0x00;

    reg {
        name = "Control";
        field {
            sw = rw; hw = r;
            desc = "1: hold the data path (sensor front end, compressor) in reset";
        } soft_reset[1:1] = 0;
    } CTRL @ 0x04;

    reg {
        name = "Status";
        field { sw = r; hw = w; desc = "Sensor run in progress"; } busy[0:0];
        field {
            sw = r; hw = w;
            desc = "An overflow counter is non-zero (emulator underrun, overrun or drop; corner turn drop; scene timestamp, link RX or ground record overflow)";
        } error[1:1];
        field { sw = r; hw = w; desc = "clk_sensor clock (MMCM) locked"; } sensor_locked[2:2];
        field {
            sw = r; hw = w;
            desc = "Register writes not yet applied in every clock domain (the link domain only while LNK.STATUS.tx_ready). Wait for 0 after configuring, before starting DMA or a run";
        } cfg_pending[3:3];
    } STATUS @ 0x08;

    reg {
        name = "Interrupt enables";
        field { sw = rw; hw = r; desc = "Compressed scene complete"; } scene_done[0:0] = 0;
        field { sw = rw; hw = r; desc = "Overflow"; } error[1:1] = 0;
        field { sw = rw; hw = r; desc = "Link lock lost"; } link_lock_loss[2:2] = 0;
        field { sw = rw; hw = r; desc = "Ground frame sync lost"; } sync_loss[3:3] = 0;
    } IRQ_EN @ 0x0C;

    reg {
        name = "Interrupt flags";
        desc = "Write 1 to clear";
        field { sw = rw; hw = r; onwrite = woclr; hwset; desc = "A compressed scene completed"; } scene_done[0:0] = 0;
        field { sw = rw; hw = r; onwrite = woclr; hwset; desc = "An overflow counter incremented"; } error[1:1] = 0;
        field { sw = rw; hw = r; onwrite = woclr; hwset; desc = "LNK.LOCK_LOSSES incremented"; } link_lock_loss[2:2] = 0;
        field { sw = rw; hw = r; onwrite = woclr; hwset; desc = "GR.SYNC_LOSSES incremented"; } sync_loss[3:3] = 0;
    } IRQ_STATUS @ 0x10;

    reg {
        name = "Build identifier";
        field { sw = r; hw = w; desc = "Git commit (short hash) of the build"; } build_id[31:0];
    } BUILD_ID @ 0x40;

    reg {
        name = "Mode";
        desc = "Both outputs may be on at once; with neither, the compressor output is discarded. Change only between runs (or under soft reset): scene timestamps are queued for the packetizer only while downlink is set.";
        field {
            sw = rw; hw = r;
            desc = "1: compressor output to DMA S2MM (CAPTURE_CMP)";
        } capture[0:0] = 1;
        field {
            sw = rw; hw = r;
            desc = "1: compressor output to the downlink chain: packets, AOS frames, RS, CADUs, error injector, link (COMPRESS; RAW with CMP.OPTS.raw)";
        } downlink[1:1] = 0;
    } MODE @ 0x44;

    reg {
        name = "DMA routing";
        field {
            sw = rw; hw = r;
            desc = "1: DMA MM2S stream to the calibration table; 0: to the sensor emulator";
        } to_table[0:0] = 0;
    } DMA_ROUTE @ 0x48;

    reg {
        name = "Pixels per line";
        field { sw = rw; hw = r; desc = "Nx, 1..NX_MAX"; } value[15:0] = 64;
    } NX @ 0x50;
    reg {
        name = "Lines per scene";
        field { sw = rw; hw = r; desc = "Ny, 1..65535"; } value[15:0] = 32;
    } NY @ 0x54;
    reg {
        name = "Bands";
        field { sw = rw; hw = r; desc = "Nz, 16..NZ_MAX"; } value[15:0] = 32;
    } NZ @ 0x58;

    reg {
        name = "Sample depth";
        field { sw = rw; hw = r; desc = "D, 2..16"; } depth[4:0] = 12;
    } DEPTH @ 0x5C;
};

// ---------------------------------------------------------------------------
regfile hpdp_se {
    name = "Sensor emulator";
    desc = "SPEC.md 6.1. Runs on clk_sensor.";

    block_id #(.BLOCK(16'h0001)) ID @ 0x00;

    reg {
        name = "Control";
        field {
            sw = rw; hw = r;
            desc = "Set to start a run (a new scene); the run ends after LINES lines, or when cleared";
        } run[0:0] = 0;
    } CTRL @ 0x04;

    reg {
        name = "Status";
        field { sw = r; hw = w; desc = "A run is in progress"; } busy[0:0];
        field { sw = r; hw = w; desc = "The run has emitted LINES lines"; } done[1:1];
    } STATUS @ 0x08;

    reg {
        name = "Line period";
        field {
            sw = rw; hw = r;
            desc = "clk_sensor cycles between line starts; at least Nx*Nz + 1";
        } cycles[31:0] = 32'd1000;
    } LINE_PERIOD @ 0x40;

    reg {
        name = "Lines per run";
        field { sw = rw; hw = r; desc = "0: until CTRL.run is cleared"; } lines[31:0] = 0;
    } LINES @ 0x44;

    reg {
        name = "Sample source";
        field { sw = rw; hw = r; desc = "0: DMA, 1: ramp, 2: LFSR"; } source[1:0] = 0;
    } SOURCE @ 0x48;

    cnt_clear CNT_CLEAR @ 0x7C;

    reg {
        name = "Line timestamp";
        field { sw = r; hw = w; desc = "Free-running count of line starts"; } value[23:0];
    } LINE_TIMESTAMP @ 0x80;
    reg {
        name = "Scene timestamp";
        field { sw = r; hw = w; desc = "LINE_TIMESTAMP when the current scene started"; } value[23:0];
    } SCENE_TIMESTAMP @ 0x84;
    counter LINES_EMITTED @ 0x88;
    counter SCENES_STARTED @ 0x8C;
    counter UNDERRUN_SAMPLES @ 0x90;
    UNDERRUN_SAMPLES -> desc = "Samples sent as 0 because DMA data was late";
    counter PERIOD_OVERRUNS @ 0x94;
    PERIOD_OVERRUNS -> desc = "Line starts delayed: line period shorter than a line";
    counter DROPPED_SAMPLES @ 0x98;
    DROPPED_SAMPLES -> desc = "Samples lost in the emulator output FIFO";
};

// ---------------------------------------------------------------------------
regfile hpdp_rc {
    name = "Radiometric correction";
    desc = "SPEC.md 6.2. Table debug access: write TBL_ADDR (and TBL_WDATA_*), then TBL_CMD; wait until STATUS.tbl_busy is 0 before the next command.";

    block_id #(.BLOCK(16'h0002)) ID @ 0x00;

    reg {
        name = "Control";
        field { sw = rw; hw = r; desc = "1: correction on; 0: bypass (output = input)"; } enable[0:0] = 1;
    } CTRL @ 0x04;

    reg {
        name = "Status";
        field { sw = r; hw = w; desc = "Table command in progress"; } tbl_busy[0:0];
    } STATUS @ 0x08;

    reg {
        name = "Clamps in the current scene";
        field { sw = r; hw = w; } count[31:0];
    } SCENE_CLAMPED @ 0x40;
    reg {
        name = "Replaced bad pixels in the current scene";
        field { sw = r; hw = w; } count[31:0];
    } SCENE_REPLACED @ 0x44;
    reg {
        name = "Last table load";
        field { sw = r; hw = w; desc = "128-bit beats (two entries each) in the last table load"; } words[31:0];
    } TBL_WORDS @ 0x48;

    reg {
        name = "Table entry address";
        field { sw = rw; hw = r; desc = "Entry z*Nx + x"; } addr[17:0] = 0;
    } TBL_ADDR @ 0x50;
    reg {
        name = "Table write data (dark, gain)";
        field { sw = rw; hw = r; } dark[15:0] = 0;
        field { sw = rw; hw = r; desc = "Unsigned Q2.14"; } gain[31:16] = 0;
    } TBL_WDATA_LO @ 0x54;
    reg {
        name = "Table write data (flags)";
        field { sw = rw; hw = r; } bad[0:0] = 0;
    } TBL_WDATA_HI @ 0x58;
    reg {
        name = "Table command";
        field { sw = rw; hw = r; singlepulse; desc = "Write 1: write TBL_WDATA_* to entry TBL_ADDR"; } write[0:0] = 0;
        field { sw = rw; hw = r; singlepulse; desc = "Write 1: read entry TBL_ADDR into TBL_RDATA_*"; } read[1:1] = 0;
    } TBL_CMD @ 0x5C;
    reg {
        name = "Table read data (dark, gain)";
        field { sw = r; hw = w; } dark[15:0];
        field { sw = r; hw = w; } gain[31:16];
    } TBL_RDATA_LO @ 0x60;
    reg {
        name = "Table read data (flags)";
        field { sw = r; hw = w; } bad[0:0];
    } TBL_RDATA_HI @ 0x64;
};

// ---------------------------------------------------------------------------
regfile hpdp_ct {
    name = "Corner turn";
    desc = "SPEC.md 6.3";

    block_id #(.BLOCK(16'h0003)) ID @ 0x00;
    cnt_clear CNT_CLEAR @ 0x7C;
    counter LINES_OUT @ 0x80;
    counter DROPPED_LINES @ 0x84;
    DROPPED_LINES -> desc = "Lines dropped (both buffers full) and sent as fill lines";
    counter UNFILLED_LINES @ 0x88;
    UNFILLED_LINES -> desc = "Dropped lines that could not be replaced by a fill line";
    counter SCENES_PADDED @ 0x8C;
    SCENES_PADDED -> desc = "Scenes cut short (by unfilled lines) and completed with zero samples before the compressor (scene guard)";
    counter SAMPLES_PADDED @ 0x90;
    SAMPLES_PADDED -> desc = "Zero samples added by the scene guard";
};

// ---------------------------------------------------------------------------
regfile hpdp_cmp {
    name = "CCSDS 123 compressor";
    desc = "SPEC.md 6.4. Image size and D come from the system block. Static while a scene is compressed.";

    block_id #(.BLOCK(16'h0004)) ID @ 0x00;

    reg {
        name = "Status";
        field { sw = r; hw = w; desc = "A scene is being compressed"; } busy[0:0];
        field { sw = r; hw = w; desc = "Configuration outside what the core supports"; } cfg_error[1:1];
    } STATUS @ 0x08;

    reg {
        name = "Prediction";
        field { sw = rw; hw = r; desc = "P, previous bands, 0..15"; } bands[3:0] = 3;
        field { sw = rw; hw = r; desc = "1: full prediction; 0: reduced"; } full[4:4] = 1;
        field { sw = rw; hw = r; desc = "0 neighbour wide, 1 neighbour narrow, 2 column wide, 3 column narrow"; } local_sum[6:5] = 0;
        field { sw = rw; hw = r; desc = "Weight resolution omega, 4..19"; } omega[12:8] = 13;
        field { sw = rw; hw = r; desc = "Register size R, max(32, D + omega + 2)..64"; } reg_size[22:16] = 32;
    } PRED @ 0x40;

    reg {
        name = "Weight update";
        field { sw = rw; hw = r; desc = "nu_min, -6..9 (two's complement)"; } v_min[4:0] = 5'h1F;
        field { sw = rw; hw = r; desc = "nu_max, nu_min..9 (two's complement)"; } v_max[12:8] = 3;
        field { sw = rw; hw = r; desc = "log2 t_inc, 4..11"; } t_inc_log2[19:16] = 6;
    } WUPD @ 0x44;

    reg {
        name = "Entropy coder and output";
        field { sw = rw; hw = r; desc = "U_max, 8..32"; } u_max[5:0] = 18;
        field { sw = rw; hw = r; desc = "gamma_0, 1..8"; } gamma0[11:8] = 1;
        field { sw = rw; hw = r; desc = "gamma*, max(4, gamma_0 + 1)..11"; } gamma_star[15:12] = 6;
        field { sw = rw; hw = r; desc = "K, 0..D-2"; } k_init[19:16] = 7;
        field { sw = rw; hw = r; desc = "Output word size B in bytes, 1..8"; } word_bytes[27:24] = 1;
    } CODER @ 0x48;

    reg {
        name = "Options";
        field { sw = rw; hw = r; desc = "1: bypass (RAW): samples packed at D bits, no header"; } raw[0:0] = 0;
        field { sw = rw; hw = r; desc = "User data byte in the header"; } user_data[15:8] = 0;
    } OPTS @ 0x4C;

    cnt_clear CNT_CLEAR @ 0x7C;
    counter SCENES_DONE @ 0x80;
    SCENES_DONE -> desc = "Compressed scenes completed (output tlast)";
    counter SAMPLES_IN @ 0x84;
    SAMPLES_IN -> desc = "Input samples since the last clear";
    counter BYTES_OUT @ 0x88;
    BYTES_OUT -> desc = "Output bytes since the last clear";
    counter LAST_BYTES @ 0x8C;
    LAST_BYTES -> desc = "Output bytes of the last completed scene";
    counter LAST_CYCLES @ 0x90;
    LAST_CYCLES -> desc = "clk_sys cycles from the last completed scene's first input sample to its last output word";
    counter OUT_STALLS @ 0x94;
    OUT_STALLS -> desc = "clk_sys cycles with output valid and not ready";
};

// ---------------------------------------------------------------------------
regfile hpdp_pkt {
    name = "Space packetizer";
    desc = "SPEC.md 6.5. clk_sys. Static while scenes are in flight.";

    block_id #(.BLOCK(16'h0005)) ID @ 0x00;

    reg {
        name = "Application process ID";
        field { sw = rw; hw = r; desc = "APID of the science packets"; } apid[10:0] = 11'h100;
    } APID @ 0x40;
    reg {
        name = "Packet data length";
        field { sw = rw; hw = r; desc = "User data bytes per packet, 1..2048; the last packet of a scene may be shorter"; } bytes[11:0] = 2048;
    } PKT_DATA @ 0x44;

    cnt_clear CNT_CLEAR @ 0x7C;
    counter PACKETS @ 0x80;
    counter SCENES @ 0x84;
    counter TS_OVERFLOWS @ 0x88;
    TS_OVERFLOWS -> desc = "Scene timestamps lost: more than 16 scenes between the front end and the packetizer";
};

// ---------------------------------------------------------------------------
regfile hpdp_aos {
    name = "AOS framer and channel coding";
    desc = "SPEC.md 6.6, 6.7: 892-byte frames, RS(255,223) I = 4, randomizer, ASM. clk_sys.";

    block_id #(.BLOCK(16'h0006)) ID @ 0x00;

    reg {
        name = "Control";
        field {
            sw = rw; hw = r;
            desc = "1: an idle frame (VCID 63) whenever no science frame is ready, so the downlink never pauses (AOS-01)";
        } idle_en[0:0] = 1;
    } CTRL @ 0x04;

    reg {
        name = "Frame header";
        field { sw = rw; hw = r; desc = "Spacecraft ID"; } scid[7:0] = 8'h42;
        field { sw = rw; hw = r; desc = "Virtual channel ID of the science frames, 0..62"; } vcid[13:8] = 1;
    } FRAME_HDR @ 0x40;
    reg {
        name = "Science frame spacing";
        field {
            sw = rw; hw = r;
            desc = "Minimum clk_sys cycles between science frame starts, 0: unlimited (AOS-02: f_clk_sys / frames per second)";
        } cycles[31:0] = 0;
    } FRAME_GAP @ 0x44;

    cnt_clear CNT_CLEAR @ 0x7C;
    counter SCIENCE_FRAMES @ 0x80;
    counter IDLE_FRAMES @ 0x84;
    counter CADUS @ 0x88;
    CADUS -> desc = "CADUs leaving the channel coder (science and idle)";
};

// ---------------------------------------------------------------------------
regfile hpdp_ei {
    name = "Error injector";
    desc = "SPEC.md 6.8, on the CADU byte stream. clk_sys. Change the settings while no CADUs flow if the change point matters.";

    block_id #(.BLOCK(16'h0007)) ID @ 0x00;

    reg {
        name = "Control";
        field { sw = rw; hw = r; desc = "0 off, 1 random bit errors, 2 burst, 3 ASM"; } mode[1:0] = 0;
    } CTRL @ 0x04;

    reg {
        name = "Random error threshold";
        field { sw = rw; hw = r; desc = "BER = THRESHOLD / 2^32 per bit"; } value[31:0] = 0;
    } THRESHOLD @ 0x40;
    reg {
        name = "Seed";
        field { sw = rw; hw = r; desc = "Generator seed, loaded by SEED_LOAD and at reset"; } value[31:0] = 1;
    } SEED @ 0x44;
    reg {
        name = "Seed load";
        field {
            sw = rw; hw = r; singlepulse;
            desc = "Write 1: restart the generators from SEED and the burst and ASM counters; clears INJECTED_BITS";
        } load[0:0] = 0;
    } SEED_LOAD @ 0x48;
    reg {
        name = "Burst length";
        field { sw = rw; hw = r; desc = "Bits per burst"; } bits[15:0] = 0;
    } BURST_LEN @ 0x4C;
    reg {
        name = "Period";
        field { sw = rw; hw = r; desc = "Burst: one burst every PERIOD bytes. ASM: every PERIOD-th CADU. At least 1"; } value[31:0] = 1;
    } PERIOD @ 0x50;
    reg {
        name = "ASM bits";
        field { sw = rw; hw = r; desc = "ASM mode: bits flipped at the start of the sync marker, 0..32"; } bits[5:0] = 0;
    } ASM_BITS @ 0x54;

    cnt_clear CNT_CLEAR @ 0x7C;
    counter INJECTED_BITS @ 0x80;
    INJECTED_BITS -> desc = "Bits flipped (ground truth for BER measurements)";
};

// ---------------------------------------------------------------------------
regfile hpdp_lnk {
    name = "Optical link";
    desc = "SPEC.md 6.9. GTH SFP0 and SFP1 at 1.25 Gbaud, both transmitting the same stream; the receiver takes one channel (CTRL.rx_sel). The link layer runs on clk_link (62.5 MHz), which runs only while the transceivers' TX is up (STATUS.tx_ready); its counters hold their last values otherwise.";

    block_id #(.BLOCK(16'h0008)) ID @ 0x00;

    reg {
        name = "Control";
        field { sw = rw; hw = r; desc = "SFP0 and SFP1 transmitters on (TX_DISABLE released, LNK-09)"; } tx_enable[0:0] = 1;
        field { sw = rw; hw = r; desc = "1: hold both GTH channels in reset; the full reset sequence runs on release"; } gt_reset[1:1] = 0;
        field { sw = rw; hw = r; desc = "1: hold the GTH receive data paths in reset"; } rx_reset[2:2] = 0;
        field { sw = rw; hw = r; desc = "1: the receiver gets the transmitted words inside the FPGA (no transceiver)"; } fabric_loopback[3:3] = 0;
        field { sw = rw; hw = r; desc = "Receiving channel: 0 SFP1 (fiber from SFP0), 1 SFP0"; } rx_sel[4:4] = 0;
        field { sw = rw; hw = r; desc = "GTH LOOPBACK: 0 normal, 1 near-end PCS, 2 near-end PMA, 4 far-end PMA, 6 far-end PCS"; } gt_loopback[10:8] = 0;
        field { sw = rw; hw = r; desc = "Invert the transmitted bits"; } tx_polarity[12:12] = 0;
        field { sw = rw; hw = r; desc = "Invert the received bits"; } rx_polarity[13:13] = 0;
        field {
            sw = rw; hw = r;
            desc = "GTH PRBS generator and checker: 0 off (link layer), 5 PRBS-31 (PRBS mode, LNK-06); 1 PRBS-7, 2 PRBS-9, 3 PRBS-15, 4 PRBS-23";
        } prbs_sel[19:16] = 0;
    } CTRL @ 0x04;

    reg {
        name = "Status";
        field { sw = r; hw = w; desc = "Transceiver TX reset done: clk_link runs"; } tx_ready[0:0];
        field { sw = r; hw = w; desc = "Transceiver RX reset done"; } rx_ready[1:1];
        field { sw = r; hw = w; desc = "Receiving channel byte-aligned on K28.5"; } aligned[2:2];
        field { sw = r; hw = w; desc = "Link layer LOCKED (LNK-05)"; } locked[3:3];
        field { sw = r; hw = w; desc = "PRBS checker of the receiving channel locked"; } prbs_locked[4:4];
        field { sw = r; hw = w; desc = "CPLL locked: [0] SFP0, [1] SFP1"; } cpll_locked[9:8];
        field { sw = r; hw = w; desc = "GTH power good: [0] SFP0, [1] SFP1"; } powergood[11:10];
    } STATUS @ 0x08;

    reg {
        name = "Clock-correction interval";
        field { sw = rw; hw = r; desc = "An idle word at least every this many words, 2..65535 (LNK-03)"; } words[15:0] = 2048;
    } CC_INTERVAL @ 0x40;
    reg {
        name = "PRBS error injection";
        field { sw = rw; hw = r; singlepulse; desc = "Write 1: one error in the transmitted PRBS (TXPRBSFORCEERR)"; } inject[0:0] = 0;
    } PRBS_INJECT @ 0x44;

    cnt_clear CNT_CLEAR @ 0x7C;
    CNT_CLEAR -> desc = "Write 1 to clear this block's counters (also resets the GTH PRBS checkers)";
    counter CODE_ERRORS @ 0x80;
    CODE_ERRORS -> desc = "Received words with a disparity or not-in-table error";
    counter LOCK_LOSSES @ 0x84;
    counter RX_WORDS @ 0x88;
    RX_WORDS -> desc = "Data words received while LOCKED";
    counter TX_DATA_WORDS @ 0x8C;
    counter TX_IDLE_WORDS @ 0x90;
    TX_IDLE_WORDS -> desc = "Idle / clock-correction words sent";
    counter RX_OVERFLOWS @ 0x94;
    RX_OVERFLOWS -> desc = "Received words lost in the clk_link -> clk_sys FIFO";
    counter CLK_CORRECTIONS @ 0x98;
    CLK_CORRECTIONS -> desc = "Elastic-buffer clock corrections (idle words removed or inserted)";
    counter BUF_ERRORS @ 0x9C;
    BUF_ERRORS -> desc = "Elastic-buffer underflows or overflows (each followed by a buffer reset)";
    counter PRBS_ERRORS @ 0xA0;
    PRBS_ERRORS -> desc = "Words with PRBS errors while CTRL.prbs_sel is set";
    counter PRBS_WORDS_LO @ 0xA4;
    PRBS_WORDS_LO -> desc = "PRBS words checked while the checker was locked, bits 31:0 (16 bits per word). Read HI, LO, HI and repeat if HI changed";
    reg {
        name = "PRBS words checked, bits 47:32";
        field { sw = r; hw = w; } count[15:0];
    } PRBS_WORDS_HI @ 0xA8;
};

// ---------------------------------------------------------------------------
regfile hpdp_gr {
    name = "Ground receiver";
    desc = "SPEC.md 6.10: frame sync, derandomizer, capture to DDR (DMA S2MM, 1024-byte records). clk_sys.";

    block_id #(.BLOCK(16'h0009)) ID @ 0x00;

    reg {
        name = "Control";
        field {
            sw = rw; hw = r;
            desc = "1: records to the ground DMA S2MM; 0: discarded (still counted)";
        } capture[0:0] = 0;
        field {
            sw = rw; hw = r;
            desc = "1: records of idle frames are not captured: VCID field nearer (in bits) to 63 than to AOS.FRAME_HDR.vcid";
        } skip_idle[1:1] = 1;
    } CTRL @ 0x04;

    reg {
        name = "Status";
        field { sw = r; hw = w; desc = "0 SEARCH, 1 VERIFY, 2 LOCK, 3 FLYWHEEL"; } sync_state[1:0];
    } STATUS @ 0x08;

    reg {
        name = "Frame sync";
        field { sw = rw; hw = r; desc = "ASM bits that may be wrong, 0..32 (GR-01)"; } asm_tol[5:0] = 2;
        field { sw = rw; hw = r; desc = "Missed ASMs coasted through in LOCK, 0..15"; } flywheel[11:8] = 3;
    } SYNC @ 0x40;
    reg {
        name = "Records per DMA transfer";
        field {
            sw = rw; hw = r;
            desc = "tlast after this many captured records, 1..65535; a partial group ends after 2^16 clk_sys cycles without a record";
        } records[15:0] = 16;
    } XFER @ 0x44;

    cnt_clear CNT_CLEAR @ 0x7C;
    counter CADUS @ 0x80;
    CADUS -> desc = "Records delivered by the frame sync";
    counter SYNC_LOSSES @ 0x84;
    counter ASM_BIT_ERRORS @ 0x88;
    counter DROPPED_RECORDS @ 0x8C;
    DROPPED_RECORDS -> desc = "Records lost because the capture path was full";
    counter SKIPPED_IDLE @ 0x90;
    counter CAPTURED @ 0x94;
    CAPTURED -> desc = "Records sent to the ground DMA";
};

// ---------------------------------------------------------------------------
addrmap hpdp_regs {
    name = "HPDP";
    desc = "Hyperspectral Payload Data Processor, base 0xA000_0000 (1 MB window)";
    default regwidth = 32;

    hpdp_sys sys @ 0x00000;
    hpdp_se  se  @ 0x10000;
    hpdp_rc  rc  @ 0x20000;
    hpdp_ct  ct  @ 0x30000;
    hpdp_cmp cmp @ 0x40000;
    hpdp_pkt pkt @ 0x50000;
    hpdp_aos aos @ 0x60000;
    hpdp_ei  ei  @ 0x70000;
    hpdp_lnk lnk @ 0x80000;
    hpdp_gr  gr  @ 0x90000;
};
